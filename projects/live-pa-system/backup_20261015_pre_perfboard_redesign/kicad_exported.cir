.title KiCad schematic
C12 /LINE_HOT_RAW /LINE_HOT_AC 1uF_Film
C13 /LINE_COLD_AC /LINE_COLD_RAW 1uF_Film
C11 /LINE_COLD_RAW GND 47p
R13 /LINE_COLD_RAW GND 100k
R12 GND /LINE_HOT_RAW 100k
C10 GND /LINE_HOT_RAW 47p
R15 /LINE_REC_INV /LINE_COLD_AC 30k_0.1%
R14 /LINE_HOT_AC /LINE_REC_NONINV 30k_0.1%
R16 /VBIAS_7V5 /LINE_REC_NONINV 10k_0.1%
R17 /LINE_REC_INV /LINE_REC_OUT 10k_0.1%
C2 /MIC_COLD_RAW GND 47p
R2 /MIC_COLD_RAW GND 100k
R1 GND /MIC_HOT_RAW 100k
C1 GND /MIC_HOT_RAW 47p
J1 __J1
J2 __J2
J3 __J3
F1 __F1
C17 /+36V GND 470uF/50V_LowESR
D1 __D1
R18 /PMOS_GATE GND 100k
Q1 __Q1
R5 /MIC_PRE1_INV /MIC_COLD_AC 2.2k_0.1%
R3 /MIC_HOT_AC /MIC_PRE1_NONINV 2.2k_0.1%
R4 /VBIAS_7V5 /MIC_PRE1_NONINV 4.7k_0.1%
U1 __U1
C4 /MIC_HOT_RAW /MIC_HOT_AC 10uF/50V_BP
C5 /MIC_COLD_AC /MIC_COLD_RAW 10uF/50V_BP
R6 /MIC_PRE1_INV /MIC_STG1_OUT 4.7k_0.1%
C6 /MIC_STG1_OUT /MIC_STG2_IN 10uF/25V
R10 /MIC_PRE2_INV /MIC_GAIN_POT_CW 1.2k_1%
RV1 __RV1
C7 /MIC_PRE_OUT /MIC_VOL_POT_IN 10uF/25V
R8 /MIC_PRE2_INV /VBIAS_7V5 330R_1%
R7 /MIC_STG2_IN /VBIAS_7V5 47k_1%
U2 __U2
C16 /+15V GND 100nF/50V
C18 /+36V GND 100nF/50V
U4 __U4
D2 __D2
R19 /+15V /LM317_ADJ 240R_1%
R20 /LM317_ADJ GND 2.64k_1%
D3 __D3
C20 /+15V GND 100uF/25V
C21 /+15V GND 100nF/50V
R22 /VBIAS_DIV GND 10k_1%
R21 /+15V /VBIAS_DIV 10k_1%
C19 /LM317_ADJ GND 10uF/25V
RV3 __RV3
C15 /LINE_REC_OUT /LINE_VOL_POT_IN 10uF/25V
SW2 __SW2
L1 /AMP_OUT_POS /SPK_OUT_POS 1.0mH_AirCore_0.35R
C24 /AMP_OUT_POS /SPK_OUT_POS 4.7uF/250V_MKP
R23 /AMP_OUT_POS /SPK_OUT_POS 8.2R_10W_NonInductive
J7 __J7
C8 /SELECTED_AUDIO /HPF_MID_NODE 68nF_Film
R9 /HPF_OUT /HPF_MID_NODE 27k_1%
RV2 __RV2
SW1 __SW1
C22 /VBIAS_DIV GND 10uF/25V
U3 __U3
C14 /HPF_OUT /AMP_INPUT_SIG 10uF/25V
TP1 __TP1
J6 __J6
R11 /HPF_NONINV /VBIAS_7V5 56k_1%
C9 /HPF_MID_NODE /HPF_NONINV 68nF_Film
R24 /AMP_INPUT_SIG GND 100k
J4 __J4
J5 __J5
C26 /+15V GND 100nF/50V
C23 /VBIAS_7V5 GND 47uF/25V
C25 /VBIAS_7V5 GND 100nF/50V
C3 /+15V GND 100nF/50V
.end
