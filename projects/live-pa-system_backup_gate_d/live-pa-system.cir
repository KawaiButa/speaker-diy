.title KiCad schematic
C14 /LINE_REC_OUT /LINE_VOL_POT_IN 10uF/25V
RV3 __RV3
RV1 __RV1
R6 /MIC_PRE_INV /MIC_GAIN_POT 100k_1%
C7 /HPF_STAGE_IN /HPF_MID_NODE 68nF_Film
R8 /HPF_OUT /HPF_MID_NODE 27k_1%
C8 /HPF_MID_NODE /HPF_NONINV 68nF_Film
R9 /HPF_NONINV /VBIAS_7V5 56k_1%
C6 /MIC_PRE_OUT /HPF_STAGE_IN 10uF/25V
R13 /LINE_REC_OUT /LINE_REC_INV 10k_1%
R4 /VBIAS_7V5 /MIC_PRE_NONINV 100k_1%
U1A __U1A
C12 /LINE_HOT_RAW /LINE_HOT_DC 1uF_Film
C13 /LINE_COLD_DC /LINE_COLD_RAW 1uF_Film
J2 __J2
C10 GND /LINE_HOT_RAW 47p
R12 /LINE_COLD_DC /LINE_REC_INV 20k_1%
R14 /LINE_REC_NONINV /LINE_HOT_DC 20k_1%
C11 /LINE_COLD_RAW GND 47p
J3 __J3
F1 __F1
Q1 __Q1
C2 /MIC_COLD_RAW GND 47p
R2 /MIC_COLD_RAW GND 100k
R3 /MIC_HOT_DC /MIC_PRE_NONINV 10k_1%
R5 /MIC_PRE_INV /MIC_COLD_DC 10k_1%
C1 GND /MIC_HOT_RAW 47p
R1 GND /MIC_HOT_RAW 100k
C4 /MIC_HOT_RAW /MIC_HOT_DC 10uF/50V_BP
C5 /MIC_COLD_DC /MIC_COLD_RAW 10uF/50V_BP
J1 __J1
SW1 __SW1
J5 __J5
J6 __J6
J4 __J4
TP1 __TP1
L1 /AMP_OUT_POS /SPK_OUT_POS 1.0mH_AirCore_0.35R
SW2 __SW2
C24 /AMP_OUT_POS /SPK_OUT_POS 4.7uF/250V_MKP
R21 /AMP_OUT_POS /SPK_OUT_POS 8.2R_10W_NonInductive
J7 __J7
C15 /+36V GND 470uF/50V_LowESR
C16 /+36V GND 100nF/50V
U3 __U3
D2 __D2
U2A __U2A
D1 __D1
R16 /PMOS_GATE GND 100k
R15 /LINE_REC_NONINV /VBIAS_7V5 10k_1%
R18 /LM317_ADJ GND 2.64k_1%
C17 /LM317_ADJ GND 10uF/25V
R19 /+15V /VBIAS_DIV 10k_1%
R20 /VBIAS_DIV GND 10k_1%
U1B __U1B
R17 /+15V /LM317_ADJ 240R_1%
D3 __D3
U2B __U2B
C21 /VBIAS_7V5 GND 100nF/50V
C19 /+15V GND 100nF/50V
C18 /+15V GND 100uF/25V
C20 /VBIAS_DIV GND 47uF/25V
RV2 __RV2
C9 /HPF_OUT /MIC_VOL_POT_IN 10uF/25V
.end
